* task 6

V0 m gnd PWL(0 0 20n 3 40n 5 60n 5 80n 3 100n 0)
R0 gnd m 1k

.TRAN 1n 100n
.END
