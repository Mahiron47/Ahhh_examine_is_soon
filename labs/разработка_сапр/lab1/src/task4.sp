* Task4

V0 0 in 5
R0 in out 1k
R1 out 0 1k

.TRAN 1n 100n
.END
