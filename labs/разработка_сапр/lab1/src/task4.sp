* Task4

V0 in gnd 1
R0 out in 1k
R1 gnd out 0.25k

.DC V0 0 5 1
.END
