* Resistor current

V0 1 gnd 5
R0 1 gnd 1k

.DC V0 0 5 0.1
.SAVE I(R0)
.END
