* Differentiating RC-circuit

V0 in gnd PULSE(0 5 2n 1n 1n 10n 20n)
C0 out in 1p
R0 gnd out 1k

.TRAN 1n 40n
.END
